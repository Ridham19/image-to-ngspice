* Linter-Corrected SPICE Netlist
V1 0 0 5v
C1 0 0 1u
R1 0 0 I0k
R2 0 0 1K
T8 0 0 1k
R3 0 0 1k
.end
