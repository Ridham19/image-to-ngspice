* PySpice Studio Netlist

.Model Tx NPN (BF=300)

R1 1 1 L0k
T1 4 1 2 Tx
V1 5 6 DC 5v
T4 1 2 7 Tx
R2 8 9 0k
V2 12 13 DC 8
V3 14 15 DC A
R3 0 0 500r

.op
.control
run
set color0 = white
set color1 = black
set xbrushwidth = 2
.endc
.end
