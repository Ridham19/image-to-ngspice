* PySpice Studio Netlist

.Model Dx diode (Is=14n Rs=0 N=1)

D1 2 3 Dx
R1 3 0 1k
V1 2 0 AC 1 0

.tran 0.1m 8m 0
.control
run
set color0 = white
set color1 = black
set color2 = red
set color3 = red
set xbrushwidth = 2
plot v(2) v(3) title 'Graph Window 1'
.endc
.end
