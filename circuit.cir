* AI Generated Circuit
.title Circuit Output
M1 0 0 model_X
.end
