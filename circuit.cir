* Linter-Corrected SPICE Netlist
R1 10 0 1k_(NEEDS_OCR)
C1 10 0 1u_(NEEDS_OCR)
R2 10 0 1k_(NEEDS_OCR)
V1 0 10 5V_(NEEDS_OCR)
R3 10 0 1k_(NEEDS_OCR)
T2 10 0 1k_(NEEDS_OCR)
V2 10 0 5V
C2 10 0 1u_(NEEDS_OCR)
R4 0 10 1k_(NEEDS_OCR)
R5 0 10 1k_(NEEDS_OCR)
.end
