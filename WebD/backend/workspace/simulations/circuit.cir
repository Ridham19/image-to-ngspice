* WebSpice Studio — Generated Netlist

.Model Dx diode (Is=14n Rs=0 N=1)

D1 Vin Vout Dx
R1 Vout 0 1k
V1 Vin 0 SINE(0 5 1k 0 0 0)

.tran 0.01m 4m 0
.control
run
set color0 = white
set color1 = black
set color2 = red
set color3 = red
set xbrushwidth = 2
print all > sim_out.txt
set hcopydevtype = svg
hardcopy plot_win1.svg v(Vin) title 'Graph Window 1'
hardcopy plot_win2.svg v(Vout) title 'Graph Window 2'
.endc
.end
