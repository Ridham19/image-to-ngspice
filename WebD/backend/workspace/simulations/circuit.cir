* WebSpice Studio — Generated Netlist

V1 1 2 DC 5

.op
.control
run
set color0 = white
set color1 = black
set xbrushwidth = 2
print all
.endc
.end
