* WebSpice Studio — Generated Netlist

.Model Tx NPN (BF=300)

Q1 Vout Vin 2 Tx
R4 0 Vin 6.8k
RC Vin 1 22k
RC Vout 1 1.0k
RE 0 2 560
V1 1 0 DC 12
V2 Vin 0 SINE(0 1 1k 0 0 0)

.tran 0.01m 8m 0
.control
run
set color0 = white
set color1 = black
set color2 = red
set color3 = red
set xbrushwidth = 2
print all > sim_out.txt
set hcopydevtype = svg
hardcopy plot_win1.svg v(Vin) title 'Graph Window 1'
hardcopy plot_win2.svg v(Vout) title 'Graph Window 2'
.endc
.end
