* WebSpice Studio — Generated Netlist

.Model Tx NPN (BF=300)

Q1 4 2 3 Tx
R2 2 1 22k
R4 0 2 22
RC 4 1 1.0k
RE 0 3 560k

.op
.control
run
set color0 = white
set color1 = black
set xbrushwidth = 2
print all > sim_out.txt
.endc
.end
