* WebSpice Studio — Generated Netlist

R1 OUTPUT 0 4k
V1 OUTPUT 0 SINE(0 5 1k 0 0 0)

.tran 0.1m 8m 0
.control
run
set color0 = white
set color1 = black
set color2 = red
set xbrushwidth = 2
print all > sim_out.txt
set hcopydevtype = svg
hardcopy plot_win1.svg v(OUTPUT) title 'Graph Window 1'
.endc
.end
