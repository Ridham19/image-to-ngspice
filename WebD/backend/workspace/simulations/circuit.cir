* WebSpice Studio — Generated Netlist

.model nmos nmos level=54
.model pmos pmos level=54

C1 Vout 0 1u ic=0
V1 1 0 DC 1.8
V2 Vin 0 PULSE(0 1.8 0 1n 1n 10m 20m)
M1 Vout Vin 0 0 nmos w=10u l=0.18u
M2 1 Vin Vout Vout pmos w=10u l=0.18u

.tran 0.1m 80m 0
.control
run
set color0 = white
set color1 = black
set color2 = red
set color3 = red
set xbrushwidth = 2
print all > sim_out.txt
set hcopydevtype = svg
hardcopy plot_win1.svg v(Vin) title 'Graph Window 1'
hardcopy plot_win2.svg v(Vout) title 'Graph Window 2'
.endc
.end
