* WebSpice Studio — Generated Netlist

.Model Tx NPN (BF=300)

Q1 4 2 3 Tx
R2 2 1 22k
R2 4 1 1.0k
R4 0 2 22
RE 0 3 560k

.tran 0.1m 80m 0
.control
run
set color0 = white
set color1 = black
set color2 = red
set xbrushwidth = 2
print all > sim_out.txt
set hcopydevtype = svg
hardcopy plot_win1.svg v(1) title 'Graph Window 1'
.endc
.end
